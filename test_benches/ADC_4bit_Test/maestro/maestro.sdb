ADE simulation setup
Run mode: Single Run, Sweeps and Corners
Tests:
  LeNet5M_TestBenches_ADC_4bit_Test_1: LeNet5M_TestBenches/ADC_4bit_Test/schematic, simulator spectre
