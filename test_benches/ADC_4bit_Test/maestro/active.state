ADE simulation setup
Test LeNet5M_TestBenches_ADC_4bit_Test_1: LeNet5M_TestBenches/ADC_4bit_Test/schematic, simulator spectre
  Models: /progs/tsmc/tsmc65/tsmcN65/../models/spectre/toplevel.scs[tt_lib]
  Temperature: 27
  Simulator options: additionalArgs=vdsatmod=gds
  Analysis tran: stop=380n errpreset=conservative
  Signals: /clk, /EN, /trigger_1, /trigger_2, /trigger_3, /trigger_4, /trigger_5, /trigger_6, /trigger_7, /trigger_8, /trigger_9, /trigger_10, /trigger_11, /trigger_12, /trigger_13, /trigger_14, /trigger_15, /trigger_16, /trigger_17, /trigger_18, /trigger_19, /trigger_20, /trigger_21, /trigger_22, /trigger_23, /trigger_24, /trigger_25, /trigger_26, /trigger_27, /trigger_28, /trigger_29, /trigger_30, /trigger_31, /trigger_32, /trigger_33, /trigger_34, /trigger_35, /trigger_36, /flag
Run mode: Single Run, Sweeps and Corners
