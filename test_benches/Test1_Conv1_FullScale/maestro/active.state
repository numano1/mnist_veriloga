ADE simulation setup
Test LeNet5M_TestBenches_Test1_Conv1_FullScale_1: LeNet5M_TestBenches/Test1_Conv1_FullScale/schematic, simulator spectre
  Models: /progs/tsmc/tsmc65/tsmcN65/../models/spectre/toplevel.scs[tt_lib]
  Temperature: 27
  Simulator options: additionalArgs=vdsatmod=gds
  Analysis tran: stop=380n errpreset=conservative
  Output conv1 out = VT("/Conv2_IN_1_<1:4>")
  Output conv2 out = VT("/I14/I0/I0/Conv2_Analog_Outs_<1:8>")
Run mode: Single Run, Sweeps and Corners
