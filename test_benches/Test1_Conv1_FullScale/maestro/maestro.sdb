ADE simulation setup
Run mode: Single Run, Sweeps and Corners
Tests:
  LeNet5M_TestBenches_Test1_Conv1_FullScale_1: LeNet5M_TestBenches/Test1_Conv1_FullScale/schematic, simulator spectre
    Outputs: conv1 out; conv2 out
