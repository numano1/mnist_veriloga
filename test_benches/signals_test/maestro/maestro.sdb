ADE simulation setup
Run mode: Single Run, Sweeps and Corners
Tests:
  LeNet5M_TestBenches_signals_test_1: LeNet5M_TestBenches/signals_test/schematic, simulator spectre
    Outputs: /out
