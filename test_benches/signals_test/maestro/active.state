ADE simulation setup
Test LeNet5M_TestBenches_signals_test_1: LeNet5M_TestBenches/signals_test/schematic, simulator spectre
  Models: /progs/tsmc/tsmc65/tsmcN65/../models/spectre/toplevel.scs[tt_lib]
  Temperature: 27
  Simulator options: additionalArgs=vdsatmod=gds
  Analysis tran: stop=360n errpreset=conservative
  Signals: /out
Run mode: Single Run, Sweeps and Corners
