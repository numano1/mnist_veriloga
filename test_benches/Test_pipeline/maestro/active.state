ADE simulation setup
Test LeNet5M_TestBenches_Test_pipeline_1: LeNet5M_TestBenches/Test_pipeline/schematic, simulator spectre
  Models: /progs/tsmc/tsmc65/tsmcN65/../models/spectre/toplevel.scs[tt_lib]
  Temperature: 27
  Simulator options: additionalArgs=vdsatmod=gds
  Files: vectors /home/pro/ferrari/onuman/tsmcN65-chip/virtuoso_tsmcN65_LP_onuman/LeNet5M_TestBenches/Verctor_files/TEST_MNIST_FULL/Images/Image10.txt /home/pro/ferrari/onuman/tsmcN65-chip/virtuoso_tsmcN65_LP_onuman/LeNet5M_TestBenches/Verctor_files/TEST_MNIST_FULL/Conv1/C1_bias.txt /home/pro/ferrari/onuman/tsmcN65-chip/virtuoso_tsmcN65_LP_onuman/LeNet5M_TestBenches/Verctor_files/TEST_MNIST_FULL/Conv1/C1_weights.txt /home/pro/ferrari/onuman/tsmcN65-chip/virtuoso_tsmcN65_LP_onuman/LeNet5M_TestBenches/Verctor_files/TEST_MNIST_FULL/Conv2/C2_w_OCH2.txt /home/pro/ferrari/onuman/tsmcN65-chip/virtuoso_tsmcN65_LP_onuman/LeNet5M_TestBenches/Verctor_files/TEST_MNIST_FULL/Conv2/C2_bias.txt /home/pro/ferrari/onuman/tsmcN65-chip/virtuoso_tsmcN65_LP_onuman/LeNet5M_TestBenches/Verctor_files/TEST_MNIST_FULL/Conv2/C2_w_OCH1.txt /home/pro/ferrari/onuman/tsmcN65-chip/virtuoso_tsmcN65_LP_onuman/LeNet5M_TestBenches/Verctor_files/TEST_MNIST_FULL/Conv2/C2_w_OCH8.txt /home/pro/ferrari/onuman/tsmcN65-chip/virtuoso_tsmcN65_LP_onuman/LeNet5M_TestBenches/Verctor_files/TEST_MNIST_FULL/Conv2/C2_w_OCH7.txt /home/pro/ferrari/onuman/tsmcN65-chip/virtuoso_tsmcN65_LP_onuman/LeNet5M_TestBenches/Verctor_files/TEST_MNIST_FULL/Conv2/C2_w_OCH6.txt /home/pro/ferrari/onuman/tsmcN65-chip/virtuoso_tsmcN65_LP_onuman/LeNet5M_TestBenches/Verctor_files/TEST_MNIST_FULL/Conv2/C2_w_OCH5.txt /home/pro/ferrari/onuman/tsmcN65-chip/virtuoso_tsmcN65_LP_onuman/LeNet5M_TestBenches/Verctor_files/TEST_MNIST_FULL/Conv2/C2_w_OCH4.txt /home/pro/ferrari/onuman/tsmcN65-chip/virtuoso_tsmcN65_LP_onuman/LeNet5M_TestBenches/Verctor_files/TEST_MNIST_FULL/Conv2/C2_w_OCH3.txt /home/pro/ferrari/onuman/tsmcN65-chip/virtuoso_tsmcN65_LP_onuman/LeNet5M_TestBenches/Verctor_files/TEST_MNIST_FULL/FLT/FLT_bias.txt /home/pro/ferrari/onuman/tsmcN65-chip/virtuoso_tsmcN65_LP_onuman/LeNet5M_TestBenches/Verctor_files/TEST_MNIST_FULL/FLT/FLT_weights.txt /home/pro/ferrari/onuman/tsmcN65-chip/virtuoso_tsmcN65_LP_onuman/LeNet5M_TestBenches/Verctor_files/TEST_MNIST_FULL/FC1/FC1_bias.txt /home/pro/ferrari/onuman/tsmcN65-chip/virtuoso_tsmcN65_LP_onuman/LeNet5M_TestBenches/Verctor_files/TEST_MNIST_FULL/FC1/FC1_weights.txt /home/pro/ferrari/onuman/tsmcN65-chip/virtuoso_tsmcN65_LP_onuman/LeNet5M_TestBenches/Verctor_files/TEST_MNIST_FULL/FC2/FC2_weights.txt /home/pro/ferrari/onuman/tsmcN65-chip/virtuoso_tsmcN65_LP_onuman/LeNet5M_TestBenches/Verctor_files/TEST_MNIST_FULL/FC2/FC2_bias.txt
  Analysis tran: stop=390n errpreset=conservative
  Output risc_en = VT("/RISCV_WRITE2L1_EN")
  Output FC_en = VT("/flag_trig_FLT")
  Output Class_0to9 = VT("/class_<0:9>")
  Output L1toL2_en = VT("/L1toL2_EN")
  Output L1toL2_clk = VT("/L1toL2_clk")
  Output L2toL3_en = VT("/L2toL3_EN")
  Output L2toL3_clk = VT("/L2toL3_clk")
  Output L1toL2_done = VT("/L1toL2_DONE")
  Output L2toL3_done = VT("/L2toL3_DONE")
  Output Iin reg = IT("/I13/I1/I0/I1/iin") (unticked)
  Output Out rerg = IT("/I13/I1/I0/I1/iout") (unticked)
  Output IT("/I13/I1/I0/I3/Iin1") (unticked)
  Output IT("/I13/I1/I0/I3/Iout") (unticked)
  Output IT("/I13/I1/I0/I4/Iin") (unticked)
  Output IT("/I13/I1/I0/I3/Iin2") (unticked)
  Signals: /I13/I1/I0/I1/iin (terminal), /I13/I1/I0/I1/iout (terminal), /I13/I1/I0/I3/Iin1 (terminal), /I13/I1/I0/I3/Iout (terminal), /I13/I1/I0/I4/Iin (terminal), /I13/I1/I0/I3/Iin2 (terminal)
Run mode: Single Run, Sweeps and Corners
