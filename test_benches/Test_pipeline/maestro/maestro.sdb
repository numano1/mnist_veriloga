ADE simulation setup
Run mode: Single Run, Sweeps and Corners
Tests:
  LeNet5M_TestBenches_Test_pipeline_1: LeNet5M_TestBenches/Test_pipeline/schematic, simulator spectre
    Outputs: Class_0to9; FC_en; risc_en; L1toL2_en; L1toL2_clk; L2toL3_en; L2toL3_clk; L1toL2_done; L2toL3_done; Iin reg; Out rerg; IT("/I13/I1/I0/I3/Iin1"); IT("/I13/I1/I0/I3/Iout"); IT("/I13/I1/I0/I4/Iin"); IT("/I13/I1/I0/I3/Iin2")
