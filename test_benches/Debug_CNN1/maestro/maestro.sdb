ADE simulation setup
Run mode: Single Run, Sweeps and Corners
Tests:
  LeNet5M_TestBenches_Debug_CNN1_1: LeNet5M_TestBenches/Debug_CNN1/schematic, simulator spectre
