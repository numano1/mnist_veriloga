ADE simulation setup
Test LeNet5M_TestBenches_Debug_CNN1_1: LeNet5M_TestBenches/Debug_CNN1/schematic, simulator spectre
  Models: /progs/tsmc/tsmc65/tsmcN65/../models/spectre/toplevel.scs[tt_lib]
  Temperature: 27
  Simulator options: additionalArgs=vdsatmod=gds
  Files: vectors /home/pro/ferrari/onuman/tsmcN65-chip/virtuoso_tsmcN65_LP_onuman/LeNet5M_TestBenches/Verctor_files/Debug_vec_files/Images/Image1.txt /home/pro/ferrari/onuman/tsmcN65-chip/virtuoso_tsmcN65_LP_onuman/LeNet5M_TestBenches/Verctor_files/Debug_vec_files/Conv1/C1_bias.txt /home/pro/ferrari/onuman/tsmcN65-chip/virtuoso_tsmcN65_LP_onuman/LeNet5M_TestBenches/Verctor_files/Debug_vec_files/Conv1/C1_weights.txt
  Analysis tran: stop=380n errpreset=conservative
  Signals: /I0/I0/I1/I1/MAC_Values_64_<1>, /I0/I0/I1/I1/MAC_Values_64_<2>, /I0/I0/I1/I1/MAC_Values_64_<3>, /I0/I0/I1/I1/MAC_Values_64_<4>, /I0/I0/I1/I1/MAC_Values_63_<1>, /I0/I0/I1/I1/MAC_Values_63_<2>, /I0/I0/I1/I1/MAC_Values_63_<3>, /I0/I0/I1/I1/MAC_Values_63_<4>, /I0/I0/I1/I1/MAC_Values_62_<1>, /I0/I0/I1/I1/MAC_Values_62_<2>, /I0/I0/I1/I1/MAC_Values_62_<3>, /I0/I0/I1/I1/MAC_Values_62_<4>, /I0/I0/I1/I1/MAC_Values_61_<1>, /I0/I0/I1/I1/MAC_Values_61_<2>, /I0/I0/I1/I1/MAC_Values_61_<3>, /I0/I0/I1/I1/MAC_Values_61_<4>, /I0/I0/I1/I1/MAC_Values_60_<1>, /I0/I0/I1/I1/MAC_Values_60_<2>, /I0/I0/I1/I1/MAC_Values_60_<3>, /I0/I0/I1/I1/MAC_Values_60_<4>, /I0/I0/I1/I1/MAC_Values_59_<1>, /I0/I0/I1/I1/MAC_Values_59_<2>, /I0/I0/I1/I1/MAC_Values_59_<3>, /I0/I0/I1/I1/MAC_Values_59_<4>, /I0/I0/I1/I1/MAC_Values_58_<1>, /I0/I0/I1/I1/MAC_Values_58_<2>, /I0/I0/I1/I1/MAC_Values_58_<3>, /I0/I0/I1/I1/MAC_Values_58_<4>, /I0/I0/I1/I1/MAC_Values_57_<1>, /I0/I0/I1/I1/MAC_Values_57_<2>, /I0/I0/I1/I1/MAC_Values_57_<3>, /I0/I0/I1/I1/MAC_Values_57_<4>, /I0/I0/I1/I1/MAC_Values_56_<1>, /I0/I0/I1/I1/MAC_Values_56_<2>, /I0/I0/I1/I1/MAC_Values_56_<3>, /I0/I0/I1/I1/MAC_Values_56_<4>, /I0/I0/I1/I1/MAC_Values_55_<1>, /I0/I0/I1/I1/MAC_Values_55_<2>, /I0/I0/I1/I1/MAC_Values_55_<3>, /I0/I0/I1/I1/MAC_Values_55_<4>, /I0/I0/I1/I1/MAC_Values_54_<1>, /I0/I0/I1/I1/MAC_Values_54_<2>, /I0/I0/I1/I1/MAC_Values_54_<3>, /I0/I0/I1/I1/MAC_Values_54_<4>, /I0/I0/I1/I1/MAC_Values_53_<1>, /I0/I0/I1/I1/MAC_Values_53_<2>, /I0/I0/I1/I1/MAC_Values_53_<3>, /I0/I0/I1/I1/MAC_Values_53_<4>, /I0/I0/I1/I1/MAC_Values_52_<1>, /I0/I0/I1/I1/MAC_Values_52_<2>, /I0/I0/I1/I1/MAC_Values_52_<3>, /I0/I0/I1/I1/MAC_Values_52_<4>, /I0/I0/I1/I1/MAC_Values_51_<1>, /I0/I0/I1/I1/MAC_Values_51_<2>, /I0/I0/I1/I1/MAC_Values_51_<3>, /I0/I0/I1/I1/MAC_Values_51_<4>, /I0/I0/I1/I1/MAC_Values_50_<1>, /I0/I0/I1/I1/MAC_Values_50_<2>, /I0/I0/I1/I1/MAC_Values_50_<3>, /I0/I0/I1/I1/MAC_Values_50_<4>, /I0/I0/I1/I1/MAC_Values_49_<1>, /I0/I0/I1/I1/MAC_Values_49_<2>, /I0/I0/I1/I1/MAC_Values_49_<3>, /I0/I0/I1/I1/MAC_Values_49_<4>, /I0/I0/I1/I1/MAC_Values_48_<1>, /I0/I0/I1/I1/MAC_Values_48_<2>, /I0/I0/I1/I1/MAC_Values_48_<3>, /I0/I0/I1/I1/MAC_Values_48_<4>, /I0/I0/I1/I1/MAC_Values_47_<1>, /I0/I0/I1/I1/MAC_Values_47_<2>, /I0/I0/I1/I1/MAC_Values_47_<3>, /I0/I0/I1/I1/MAC_Values_47_<4>, /I0/I0/I1/I1/MAC_Values_46_<1>, /I0/I0/I1/I1/MAC_Values_46_<2>, /I0/I0/I1/I1/MAC_Values_46_<3>, /I0/I0/I1/I1/MAC_Values_46_<4>, /I0/I0/I1/I1/MAC_Values_45_<1>, /I0/I0/I1/I1/MAC_Values_45_<2>, /I0/I0/I1/I1/MAC_Values_45_<3>, /I0/I0/I1/I1/MAC_Values_45_<4>, /I0/I0/I1/I1/MAC_Values_44_<1>, /I0/I0/I1/I1/MAC_Values_44_<2>, /I0/I0/I1/I1/MAC_Values_44_<3>, /I0/I0/I1/I1/MAC_Values_44_<4>, /I0/I0/I1/I1/MAC_Values_43_<1>, /I0/I0/I1/I1/MAC_Values_43_<2>, /I0/I0/I1/I1/MAC_Values_43_<3>, /I0/I0/I1/I1/MAC_Values_43_<4>, /I0/I0/I1/I1/MAC_Values_42_<1>, /I0/I0/I1/I1/MAC_Values_42_<2>, /I0/I0/I1/I1/MAC_Values_42_<3>, /I0/I0/I1/I1/MAC_Values_42_<4>, /I0/I0/I1/I1/MAC_Values_41_<1>, /I0/I0/I1/I1/MAC_Values_41_<2>, /I0/I0/I1/I1/MAC_Values_41_<3>, /I0/I0/I1/I1/MAC_Values_41_<4>, /I0/I0/I1/I1/MAC_Values_40_<1>, /I0/I0/I1/I1/MAC_Values_40_<2>, /I0/I0/I1/I1/MAC_Values_40_<3>, /I0/I0/I1/I1/MAC_Values_40_<4>, /I0/I0/I1/I1/MAC_Values_39_<1>, /I0/I0/I1/I1/MAC_Values_39_<2>, /I0/I0/I1/I1/MAC_Values_39_<3>, /I0/I0/I1/I1/MAC_Values_39_<4>, /I0/I0/I1/I1/MAC_Values_38_<1>, /I0/I0/I1/I1/MAC_Values_38_<2>, /I0/I0/I1/I1/MAC_Values_38_<3>, /I0/I0/I1/I1/MAC_Values_38_<4>, /I0/I0/I1/I1/MAC_Values_37_<1>, /I0/I0/I1/I1/MAC_Values_37_<2>, /I0/I0/I1/I1/MAC_Values_37_<3>, /I0/I0/I1/I1/MAC_Values_37_<4>, /I0/I0/I1/I1/MAC_Values_36_<1>, /I0/I0/I1/I1/MAC_Values_36_<2>, /I0/I0/I1/I1/MAC_Values_36_<3>, /I0/I0/I1/I1/MAC_Values_36_<4>, /I0/I0/I1/I1/MAC_Values_35_<1>, /I0/I0/I1/I1/MAC_Values_35_<2>, /I0/I0/I1/I1/MAC_Values_35_<3>, /I0/I0/I1/I1/MAC_Values_35_<4>, /I0/I0/I1/I1/MAC_Values_34_<1>, /I0/I0/I1/I1/MAC_Values_34_<2>, /I0/I0/I1/I1/MAC_Values_34_<3>, /I0/I0/I1/I1/MAC_Values_34_<4>, /I0/I0/I1/I1/MAC_Values_33_<1>, /I0/I0/I1/I1/MAC_Values_33_<2>, /I0/I0/I1/I1/MAC_Values_33_<3>, /I0/I0/I1/I1/MAC_Values_33_<4>, /I0/I0/I1/I1/MAC_Values_32_<1>, /I0/I0/I1/I1/MAC_Values_32_<2>, /I0/I0/I1/I1/MAC_Values_32_<3>, /I0/I0/I1/I1/MAC_Values_32_<4>, /I0/I0/I1/I1/MAC_Values_31_<1>, /I0/I0/I1/I1/MAC_Values_31_<2>, /I0/I0/I1/I1/MAC_Values_31_<3>, /I0/I0/I1/I1/MAC_Values_31_<4>, /I0/I0/I1/I1/MAC_Values_30_<1>, /I0/I0/I1/I1/MAC_Values_30_<2>, /I0/I0/I1/I1/MAC_Values_30_<3>, /I0/I0/I1/I1/MAC_Values_30_<4>, /I0/I0/I1/I1/MAC_Values_29_<1>, /I0/I0/I1/I1/MAC_Values_29_<2>, /I0/I0/I1/I1/MAC_Values_29_<3>, /I0/I0/I1/I1/MAC_Values_29_<4>, /I0/I0/I1/I1/MAC_Values_28_<1>, /I0/I0/I1/I1/MAC_Values_28_<2>, /I0/I0/I1/I1/MAC_Values_28_<3>, /I0/I0/I1/I1/MAC_Values_28_<4>, /I0/I0/I1/I1/MAC_Values_27_<1>, /I0/I0/I1/I1/MAC_Values_27_<2>, /I0/I0/I1/I1/MAC_Values_27_<3>, /I0/I0/I1/I1/MAC_Values_27_<4>, /I0/I0/I1/I1/MAC_Values_26_<1>, /I0/I0/I1/I1/MAC_Values_26_<2>, /I0/I0/I1/I1/MAC_Values_26_<3>, /I0/I0/I1/I1/MAC_Values_26_<4>, /I0/I0/I1/I1/MAC_Values_25_<1>, /I0/I0/I1/I1/MAC_Values_25_<2>, /I0/I0/I1/I1/MAC_Values_25_<3>, /I0/I0/I1/I1/MAC_Values_25_<4>, /I0/I0/I1/I1/MAC_Values_24_<1>, /I0/I0/I1/I1/MAC_Values_24_<2>, /I0/I0/I1/I1/MAC_Values_24_<3>, /I0/I0/I1/I1/MAC_Values_24_<4>, /I0/I0/I1/I1/MAC_Values_23_<1>, /I0/I0/I1/I1/MAC_Values_23_<2>, /I0/I0/I1/I1/MAC_Values_23_<3>, /I0/I0/I1/I1/MAC_Values_23_<4>, /I0/I0/I1/I1/MAC_Values_22_<1>, /I0/I0/I1/I1/MAC_Values_22_<2>, /I0/I0/I1/I1/MAC_Values_22_<3>, /I0/I0/I1/I1/MAC_Values_22_<4>, /I0/I0/I1/I1/MAC_Values_21_<1>, /I0/I0/I1/I1/MAC_Values_21_<2>, /I0/I0/I1/I1/MAC_Values_21_<3>, /I0/I0/I1/I1/MAC_Values_21_<4>, /I0/I0/I1/I1/MAC_Values_20_<1>, /I0/I0/I1/I1/MAC_Values_20_<2>, /I0/I0/I1/I1/MAC_Values_20_<3>, /I0/I0/I1/I1/MAC_Values_20_<4>, /I0/I0/I1/I1/MAC_Values_19_<1>, /I0/I0/I1/I1/MAC_Values_19_<2>, /I0/I0/I1/I1/MAC_Values_19_<3>, /I0/I0/I1/I1/MAC_Values_19_<4>, /I0/I0/I1/I1/MAC_Values_18_<1>, /I0/I0/I1/I1/MAC_Values_18_<2>, /I0/I0/I1/I1/MAC_Values_18_<3>, /I0/I0/I1/I1/MAC_Values_18_<4>, /I0/I0/I1/I1/MAC_Values_17_<1>, /I0/I0/I1/I1/MAC_Values_17_<2>, /I0/I0/I1/I1/MAC_Values_17_<3>, /I0/I0/I1/I1/MAC_Values_17_<4>, /I0/I0/I1/I1/MAC_Values_16_<1>, /I0/I0/I1/I1/MAC_Values_16_<2>, /I0/I0/I1/I1/MAC_Values_16_<3>, /I0/I0/I1/I1/MAC_Values_16_<4>, /I0/I0/I1/I1/MAC_Values_15_<1>, /I0/I0/I1/I1/MAC_Values_15_<2>, /I0/I0/I1/I1/MAC_Values_15_<3>, /I0/I0/I1/I1/MAC_Values_15_<4>, /I0/I0/I1/I1/MAC_Values_14_<1>, /I0/I0/I1/I1/MAC_Values_14_<2>, /I0/I0/I1/I1/MAC_Values_14_<3>, /I0/I0/I1/I1/MAC_Values_14_<4>, /I0/I0/I1/I1/MAC_Values_13_<1>, /I0/I0/I1/I1/MAC_Values_13_<2>, /I0/I0/I1/I1/MAC_Values_13_<3>, /I0/I0/I1/I1/MAC_Values_13_<4>, /I0/I0/I1/I1/MAC_Values_12_<1>, /I0/I0/I1/I1/MAC_Values_12_<2>, /I0/I0/I1/I1/MAC_Values_12_<3>, /I0/I0/I1/I1/MAC_Values_12_<4>, /I0/I0/I1/I1/MAC_Values_11_<1>, /I0/I0/I1/I1/MAC_Values_11_<2>, /I0/I0/I1/I1/MAC_Values_11_<3>, /I0/I0/I1/I1/MAC_Values_11_<4>, /I0/I0/I1/I1/MAC_Values_10_<1>, /I0/I0/I1/I1/MAC_Values_10_<2>, /I0/I0/I1/I1/MAC_Values_10_<3>, /I0/I0/I1/I1/MAC_Values_10_<4>, /I0/I0/I1/I1/MAC_Values_9_<1>, /I0/I0/I1/I1/MAC_Values_9_<2>, /I0/I0/I1/I1/MAC_Values_9_<3>, /I0/I0/I1/I1/MAC_Values_9_<4>, /I0/I0/I1/I1/MAC_Values_8_<1>, /I0/I0/I1/I1/MAC_Values_8_<2>, /I0/I0/I1/I1/MAC_Values_8_<3>, /I0/I0/I1/I1/MAC_Values_8_<4>, /I0/I0/I1/I1/MAC_Values_7_<1>, /I0/I0/I1/I1/MAC_Values_7_<2>, /I0/I0/I1/I1/MAC_Values_7_<3>, /I0/I0/I1/I1/MAC_Values_7_<4>, /I0/I0/I1/I1/MAC_Values_6_<1>, /I0/I0/I1/I1/MAC_Values_6_<2>, /I0/I0/I1/I1/MAC_Values_6_<3>, /I0/I0/I1/I1/MAC_Values_6_<4>, /I0/I0/I1/I1/MAC_Values_5_<1>, /I0/I0/I1/I1/MAC_Values_5_<2>, /I0/I0/I1/I1/MAC_Values_5_<3>, /I0/I0/I1/I1/MAC_Values_5_<4>, /I0/I0/I1/I1/MAC_Values_4_<1>, /I0/I0/I1/I1/MAC_Values_4_<2>, /I0/I0/I1/I1/MAC_Values_4_<3>, /I0/I0/I1/I1/MAC_Values_4_<4>, /I0/I0/I1/I1/MAC_Values_3_<1>, /I0/I0/I1/I1/MAC_Values_3_<2>, /I0/I0/I1/I1/MAC_Values_3_<3>, /I0/I0/I1/I1/MAC_Values_3_<4>, /I0/I0/I1/I1/MAC_Values_2_<1>, /I0/I0/I1/I1/MAC_Values_2_<2>, /I0/I0/I1/I1/MAC_Values_2_<3>, /I0/I0/I1/I1/MAC_Values_2_<4>, /I0/I0/I1/I1/MAC_Values_1_<1>, /I0/I0/I1/I1/MAC_Values_1_<2>, /I0/I0/I1/I1/MAC_Values_1_<3>, /I0/I0/I1/I1/MAC_Values_1_<4>, /L2toL3_clk, /L2toL3_DONE
Run mode: Single Run, Sweeps and Corners
