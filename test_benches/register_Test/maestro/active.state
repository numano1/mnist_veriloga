ADE simulation setup
Test LeNet5M_TestBenches_register_Test_1: LeNet5M_TestBenches/register_Test/schematic, simulator spectre
  Models: /progs/tsmc/tsmc65/tsmcN65/../models/spectre/toplevel.scs[tt_lib]
  Temperature: 27
  Simulator options: additionalArgs=vdsatmod=gds
  Analysis tran: stop=370n errpreset=conservative
  Signals: /TRIG, /d3, /d2, /d1, /d0
Run mode: Single Run, Sweeps and Corners
