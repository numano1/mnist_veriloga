ADE simulation setup
Run mode: Single Run, Sweeps and Corners
Tests:
  LeNet5M_TestBenches_register_Test_1: LeNet5M_TestBenches/register_Test/schematic, simulator spectre
