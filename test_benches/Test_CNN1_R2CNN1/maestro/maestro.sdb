ADE simulation setup
Run mode: Single Run, Sweeps and Corners
Tests:
  LeNet5M_TestBenches_Test_CNN1_R2CNN1_1: LeNet5M_TestBenches/Test_CNN1_R2CNN1/schematic, simulator spectre
    Outputs: clk1; clk2_main; en1; data_write_en; C1_Out_P1; C1_Out_P2; C1_Out_P3; C1_Out_P4; C1_Out_P5; C1_Out_P6; C1_Out_P7; C1_Out_P8; C1_Out_P9; C1_Out_P10; C1_Out_P11; C1_Out_P12; C1_Out_P13; C1_Out_P14; C1_Out_P15; C1_Out_P16; en2_main; flag1; flag2; Analog_Vins; if(((time >= start_time) && (time <= stop_time)) VT("/Conv2_IN_1_<1:4>") 0); C2_Ana_Outs; IT("/I0/I0/I1/I1/I0/I0/I0/I0/I4/Iout"); Imul_1cel_out; Iswitch_1cel_in; Iswitch_1cel_out; I3x3MACP_out; I3x3MACN_out; I3x3MACP_out2; I3x3MACN_out2; Ipreg_in; Ipreg_out; Inreg_in; Inreg_out1; sub_in1; sub_in2; sub_out; iv_in; iv_out; iv_out_v; c2_outputs; ioutp_4chs; ioutn_4chs; Iin_sub_1; Iin_sub_2; iout_sub; Iin_iv; Vout_Iv; regulator_c2; Ip1; Ip2; Ip3; Ip4; Ipreg1; Ipreg2; Ipreg3; Ipreg4; Isumreg; c1_outputs; iReLU_in; iReLU_out; Flat_trigger
