ADE simulation setup
Test LeNet5M_TestBenches_Test_CNN1_R2CNN1_1: LeNet5M_TestBenches/Test_CNN1_R2CNN1/schematic, simulator spectre
  Models: /progs/tsmc/tsmc65/tsmcN65/../models/spectre/toplevel.scs[tt_lib]
  Temperature: 27
  Simulator options: additionalArgs=vdsatmod=gds
  Files: vectors /home/pro/ferrari/onuman/tsmcN65-chip/virtuoso_tsmcN65_LP_onuman/LeNet5M_TestBenches/Verctor_files/test_MNIST/Images/Image1.txt /home/pro/ferrari/onuman/tsmcN65-chip/virtuoso_tsmcN65_LP_onuman/LeNet5M_TestBenches/Verctor_files/test_MNIST/Conv1/C1_bias.txt /home/pro/ferrari/onuman/tsmcN65-chip/virtuoso_tsmcN65_LP_onuman/LeNet5M_TestBenches/Verctor_files/test_MNIST/Conv1/C1_weights.txt /home/pro/ferrari/onuman/tsmcN65-chip/virtuoso_tsmcN65_LP_onuman/LeNet5M_TestBenches/Verctor_files/test_MNIST/Conv2/C2_w_OCH1.txt /home/pro/ferrari/onuman/tsmcN65-chip/virtuoso_tsmcN65_LP_onuman/LeNet5M_TestBenches/Verctor_files/test_MNIST/Conv2/C2_bias.txt /home/pro/ferrari/onuman/tsmcN65-chip/virtuoso_tsmcN65_LP_onuman/LeNet5M_TestBenches/Verctor_files/test_MNIST/Conv2/C2_w_OCH8.txt /home/pro/ferrari/onuman/tsmcN65-chip/virtuoso_tsmcN65_LP_onuman/LeNet5M_TestBenches/Verctor_files/test_MNIST/Conv2/C2_w_OCH7.txt /home/pro/ferrari/onuman/tsmcN65-chip/virtuoso_tsmcN65_LP_onuman/LeNet5M_TestBenches/Verctor_files/test_MNIST/Conv2/C2_w_OCH6.txt /home/pro/ferrari/onuman/tsmcN65-chip/virtuoso_tsmcN65_LP_onuman/LeNet5M_TestBenches/Verctor_files/test_MNIST/Conv2/C2_w_OCH5.txt /home/pro/ferrari/onuman/tsmcN65-chip/virtuoso_tsmcN65_LP_onuman/LeNet5M_TestBenches/Verctor_files/test_MNIST/Conv2/C2_w_OCH4.txt /home/pro/ferrari/onuman/tsmcN65-chip/virtuoso_tsmcN65_LP_onuman/LeNet5M_TestBenches/Verctor_files/test_MNIST/Conv2/C2_w_OCH3.txt /home/pro/ferrari/onuman/tsmcN65-chip/virtuoso_tsmcN65_LP_onuman/LeNet5M_TestBenches/Verctor_files/test_MNIST/Conv2/C2_w_OCH2.txt
  Analysis tran: stop=390n errpreset=conservative
  Output clk1 = VT("/L1toL2_clk")
  Output clk2_main = VT("/L2toL3_clk")
  Output en1 = VT("/L1toL2_EN")
  Output en2_main = VT("/L2toL3_EN")
  Output data_write_en = VT("/RISCV_WRITE2L1_EN")
  Output C1_Out_P1 = VT("/Conv2_IN_1_<1:4>")
  Output C1_Out_P2 = VT("/Conv2_IN_2_<1:4>")
  Output C1_Out_P3 = VT("/Conv2_IN_3_<1:4>")
  Output C1_Out_P4 = VT("/Conv2_IN_4_<1:4>")
  Output C1_Out_P5 = VT("/Conv2_IN_5_<1:4>")
  Output C1_Out_P6 = VT("/Conv2_IN_6_<1:4>")
  Output C1_Out_P7 = VT("/Conv2_IN_7_<1:4>")
  Output C1_Out_P8 = VT("/Conv2_IN_8_<1:4>")
  Output C1_Out_P9 = VT("/Conv2_IN_9_<1:4>")
  Output C1_Out_P10 = VT("/Conv2_IN_10_<1:4>")
  Output C1_Out_P11 = VT("/Conv2_IN_11_<1:4>")
  Output C1_Out_P12 = VT("/Conv2_IN_12_<1:4>")
  Output C1_Out_P13 = VT("/Conv2_IN_13_<1:4>")
  Output C1_Out_P14 = VT("/Conv2_IN_14_<1:4>")
  Output C1_Out_P15 = VT("/Conv2_IN_15_<1:4>")
  Output C1_Out_P16 = VT("/Conv2_IN_16_<1:4>")
  Output flag1 = VT("/L1toL2_DONE")
  Output flag2 = VT("/L2toL3_DONE")
  Output Analog_Vins = VT("/I0/I0/I1/Analog_Inputs_<1:100>")
  Output C2_Ana_Outs = VT("/I14/I0/I0/Conv2_Analog_Outs_<1:8>")
  Output Imul_1cel_out = IT("/I0/I0/I1/I1/I0/I0/I0/I0/I0/I0/I0/I0/iout")
  Output Iswitch_1cel_in = IT("/I0/I0/I1/I1/I0/I0/I0/I0/I0/I0/I0/I1/V1")
  Output Iswitch_1cel_out = IT("/I0/I0/I1/I1/I0/I0/I0/I0/I0/I0/I0/I1/V2")
  Output I3x3MACP_out = IT("/I0/I0/I1/I1/I0/I0/I0/I0/I0/I0/ioutp")
  Output I3x3MACN_out = IT("/I0/I0/I1/I1/I0/I0/I0/I0/I0/I0/ioutn")
  Output I3x3MACP_out2 = IT("/I0/I0/I1/I1/I0/I0/I0/I0/I0/ioutp")
  Output I3x3MACN_out2 = IT("/I0/I0/I1/I1/I0/I0/I0/I0/I0/ioutn")
  Output Ipreg_in = IT("/I0/I0/I1/I1/I0/I0/I0/I0/I1/iin")
  Output Ipreg_out = IT("/I0/I0/I1/I1/I0/I0/I0/I0/I1/iout")
  Output Inreg_in = IT("/I0/I0/I1/I1/I0/I0/I0/I0/I2/iin")
  Output Inreg_out1 = IT("/I0/I0/I1/I1/I0/I0/I0/I0/I2/iout")
  Output sub_in1 = IT("/I0/I0/I1/I1/I0/I0/I0/I0/I4/Iin1")
  Output sub_in2 = IT("/I0/I0/I1/I1/I0/I0/I0/I0/I4/Iin2")
  Output sub_out = IT("/I0/I0/I1/I1/I0/I0/I0/I0/I4/Iout")
  Output iv_in = IT("/I0/I0/I1/I1/I0/I0/I0/I0/I7/Iin")
  Output iv_out = IT("/I0/I0/I1/I1/I0/I0/I0/I0/I7/vout")
  Output iv_out_v = VT("/I0/I0/I1/I1/I0/I0/I0/I0/net5")
  Output c2_outputs = 2
  Output ioutp_4chs = IT("/I14/I0/I0/I0/I3/I0/I0/I0/I0/ioutp")
  Output ioutn_4chs = IT("/I14/I0/I0/I0/I3/I0/I0/I0/I0/ioutn")
  Output Iin_sub_1 = IT("/I14/I0/I0/I0/I3/I0/I0/I0/I3/Iin1")
  Output Iin_sub_2 = IT("/I14/I0/I0/I0/I3/I0/I0/I0/I3/Iin2")
  Output iout_sub = IT("/I14/I0/I0/I0/I3/I0/I0/I0/I3/Iout")
  Output Iin_iv = IT("/I14/I0/I0/I0/I3/I0/I0/I0/I8/Iin")
  Output Vout_Iv = VT("/I14/I0/I0/I0/I3/I0/I0/I0/net4")
  Output regulator_c2 = 3
  Output Ip1 = IT("/I14/I0/I0/I0/I3/I0/I0/I0/I0/I0/I0/ioutp")
  Output Ip2 = IT("/I14/I0/I0/I0/I3/I0/I0/I0/I0/I0/I1/ioutp")
  Output Ip3 = IT("/I14/I0/I0/I0/I3/I0/I0/I0/I0/I0/I2/ioutp")
  Output Ip4 = IT("/I14/I0/I0/I0/I3/I0/I0/I0/I0/I0/I3/ioutp")
  Output Ipreg1 = IT("/I14/I0/I0/I0/I3/I0/I0/I0/I0/I0/I4/Iin1")
  Output Ipreg2 = IT("/I14/I0/I0/I0/I3/I0/I0/I0/I0/I0/I4/Iin2")
  Output Ipreg3 = IT("/I14/I0/I0/I0/I3/I0/I0/I0/I0/I0/I4/Iin3")
  Output Ipreg4 = IT("/I14/I0/I0/I0/I3/I0/I0/I0/I0/I0/I4/Iin4")
  Output Isumreg = IT("/I14/I0/I0/I0/I3/I0/I0/I0/I0/I0/I4/iout")
  Output c1_outputs = 1
  Output iReLU_in = IT("/I0/I0/I1/I1/I0/I0/I0/I0/I9/iin") (unticked)
  Output iReLU_out = IT("/I0/I0/I1/I1/I0/I0/I0/I0/I9/iout") (unticked)
  Output Flat_trigger = VT("/flag_trig_FC")
  Signals: /I0/I0/I1/I1/I0/I0/I0/I0/I0/I0/I0/I0/iout (terminal), /I0/I0/I1/I1/I0/I0/I0/I0/I0/I0/I0/I1/V1 (terminal), /I0/I0/I1/I1/I0/I0/I0/I0/I0/I0/I0/I1/V2 (terminal), /I0/I0/I1/I1/I0/I0/I0/I0/I0/I0/ioutp (terminal), /I0/I0/I1/I1/I0/I0/I0/I0/I0/I0/ioutn (terminal), /I0/I0/I1/I1/I0/I0/I0/I0/I0/ioutp (terminal), /I0/I0/I1/I1/I0/I0/I0/I0/I0/ioutn (terminal), /I0/I0/I1/I1/I0/I0/I0/I0/I1/iin (terminal), /I0/I0/I1/I1/I0/I0/I0/I0/I1/iout (terminal), /I0/I0/I1/I1/I0/I0/I0/I0/I2/iin (terminal), /I0/I0/I1/I1/I0/I0/I0/I0/I2/iout (terminal), /I0/I0/I1/I1/I0/I0/I0/I0/I4/Iin1 (terminal), /I0/I0/I1/I1/I0/I0/I0/I0/I4/Iin2 (terminal), /I0/I0/I1/I1/I0/I0/I0/I0/I4/Iout (terminal), /I0/I0/I1/I1/I0/I0/I0/I0/I7/Iin (terminal), /I0/I0/I1/I1/I0/I0/I0/I0/I7/vout (terminal), /I14/I0/I0/I0/I3/I0/I0/I0/I0/ioutp (terminal), /I14/I0/I0/I0/I3/I0/I0/I0/I0/ioutn (terminal), /I14/I0/I0/I0/I3/I0/I0/I0/I3/Iin1 (terminal), /I14/I0/I0/I0/I3/I0/I0/I0/I3/Iin2 (terminal), /I14/I0/I0/I0/I3/I0/I0/I0/I3/Iout (terminal), /I14/I0/I0/I0/I3/I0/I0/I0/I8/Iin (terminal), /I14/I0/I0/I0/I3/I0/I0/I0/I0/I0/I0/ioutp (terminal), /I14/I0/I0/I0/I3/I0/I0/I0/I0/I0/I1/ioutp (terminal), /I14/I0/I0/I0/I3/I0/I0/I0/I0/I0/I2/ioutp (terminal), /I14/I0/I0/I0/I3/I0/I0/I0/I0/I0/I3/ioutp (terminal), /I14/I0/I0/I0/I3/I0/I0/I0/I0/I0/I4/Iin1 (terminal), /I14/I0/I0/I0/I3/I0/I0/I0/I0/I0/I4/Iin2 (terminal), /I14/I0/I0/I0/I3/I0/I0/I0/I0/I0/I4/Iin3 (terminal), /I14/I0/I0/I0/I3/I0/I0/I0/I0/I0/I4/Iin4 (terminal), /I14/I0/I0/I0/I3/I0/I0/I0/I0/I0/I4/iout (terminal)
Run mode: Single Run, Sweeps and Corners
