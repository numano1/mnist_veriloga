// VerilogA for PipeLine_CNN1_448A_ReLU_AP_HW_MeM_VAModel, MuxSelector_Actf, veriloga

`include "constants.vams"
`include "disciplines.vams"

module C2_MuxSelector_Actf(input act1, input act2, input act3, output out, input [1:0] SEL);
  electrical act1, act2, act3, out;
  electrical [1:0] SEL;

  // Parameters for the control voltage levels.
  parameter real Vhigh = 1.2;    // Voltage that closes a mux.
  parameter real Vlow  = 0.0;    // Voltage that leaves a mux open.
  parameter real Vth_sel = 0.6;  // Threshold to decide if a select input is "high"

  // Internal electrical nodes to drive each mux control
  electrical ctrl1_node, ctrl2_node, ctrl3_node;

  analog begin
    // Decide which mux is closed based on the two-bit select signal:
    if ((V(SEL[0]) < Vth_sel) && (V(SEL[1]) < Vth_sel)) begin
      // 00: No mux closed.
      V(ctrl1_node) <+ Vhigh;
      V(ctrl2_node) <+ Vlow;
      V(ctrl3_node) <+ Vlow;
    end else if ((V(SEL[0]) > Vth_sel) && (V(SEL[1]) < Vth_sel)) begin
      // 01: First mux closed.
      V(ctrl1_node) <+ Vhigh;
      V(ctrl2_node) <+ Vlow;
      V(ctrl3_node) <+ Vlow;
    end else if ((V(SEL[0]) < Vth_sel) && (V(SEL[1]) > Vth_sel)) begin
      // 10: Second mux closed.
      V(ctrl1_node) <+ Vlow;
      V(ctrl2_node) <+ Vhigh;
      V(ctrl3_node) <+ Vlow;
    end else if ((V(SEL[0]) > Vth_sel) && (V(SEL[1]) > Vth_sel)) begin
      // 11: Third mux closed.
      V(ctrl1_node) <+ Vlow;
      V(ctrl2_node) <+ Vlow;
      V(ctrl3_node) <+ Vhigh;
    end
  end

  // Instantiate the three muxes.
  // Each mux connects one activation function output (act1, act2, act3)
  // to the common output "out", with its control signal driven by the
  // corresponding internal control node.
  PassGate_Switch mux1(.V1(act1), .V2(out), .Ctrl(ctrl1_node));
  PassGate_Switch mux2(.V1(act2), .V2(out), .Ctrl(ctrl2_node));
  PassGate_Switch mux3(.V1(act3), .V2(out), .Ctrl(ctrl3_node));

endmodule
